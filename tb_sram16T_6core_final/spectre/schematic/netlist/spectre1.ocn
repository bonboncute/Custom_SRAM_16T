simulator( 'spectre )
design(	 "/home/disk/simulation/SIM_IC61/tb_sram16T_6core_final/spectre/schematic/netlist/netlist")
resultsDir( "/home/disk/simulation/SIM_IC61/tb_sram16T_6core_final/spectre/schematic" )
modelFile(
    '("/home/work/gpdk045_v_5_0/gpdk045/../models/spectre/gpdk045.scs" "mc")
)
analysis('tran ?stop "40n"  )
envOption(
	'analysisOrder  list("tran")
)
converge( 'ic "/Q" "0" )
converge( 'ic "/QB" "1" )
temp( 27 )
run()
selectResult( 'tran )
plot(getData("/net4") getData("/net3") getData("/QB") getData("/Q") )
modelFile(
    '("/home/work/gpdk045_v_5_0/gpdk045/../models/spectre/gpdk045.scs" "mc")
)
delete( 'converge 'ic "/Q" )
delete( 'converge 'ic "/QB" )
run()
selectResult( 'tran )
plot(getData("/Q") getData("/QB") getData("/net3") getData("/net4") )
modelFile(
    '("/home/work/gpdk045_v_5_0/gpdk045/../models/spectre/gpdk045.scs" "mc")
)
run()
selectResult( 'tran )
plot(getData("/Q") getData("/QB") getData("/net3") getData("/net4") )
