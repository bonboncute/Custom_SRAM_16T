simulator( 'spectre )
design(	 "/home/disk/simulation/SIM_IC61/tb_sram16T_6core_final/spectre/schematic/netlist/netlist")
resultsDir( "/home/disk/simulation/SIM_IC61/tb_sram16T_6core_final/spectre/schematic" )
modelFile(
    '("/home/work/gpdk045_v_5_0/gpdk045/../models/spectre/gpdk045.scs" "mc")
)
analysis('tran ?stop "10n"  )
envOption(
	'analysisOrder  list("tran")
)
temp( 27 )
run()
selectResult( 'tran )
plot(getData("/net4") getData("/net3") getData("/QB") getData("/Q") )
